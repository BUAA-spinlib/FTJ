//Title:	Compact model of Co/BaTiO3/La0.67Sr0.33MnO3 Ferroelectric Tunnel Junction
//Version:	Beta.3.0
//Date:		19 June 2015
//Language:	VerilogA
//Property:	Institut D'Electronique Fondamentale, Univ.Paris Sud / UMR 8622, CNRS
//Authors:	Zhaohao WANG, Weisheng ZHAO and Jacques-Olivier KLEIN

/*------------------------------ Brief Introduction --------------------------------

In this model, it takes into account the following behaviors
1.Tunneling resistance described by Gruverman model and FN tunneling model
2.Domain nucleation and domain wall propagation conforming to KAI model, Merz's law
	and creep process model
3.Memristive effect induced by the domain kinetics
More details can be found in chapter 3 of Zhaohao's Thesis

------------------------------------- End ---------------------------------------*/

`resetall
`include "constants.vams"
`include "disciplines.vams"

/*-------------------------------------- Electrical Constants --------------------------------------*/

`define e 1.6e-19		//Elementary charge
`define kB 1.38e-23		//Boltzmann constant
`define hbas 1.054e-34	//Reduced Planck constant
`define m 9.11e-31		//Vacuum electron mass
`define E0 1.0e9		//Characteristic field in V/m
`define PI 3.141592653

/*---------------------------------------------- End ----------------------------------------------*/

module BTOFTJ(T1,T2,s);

inout T1,T2;		//Real pins of the FTJ
output s;			//Virtual pin outputting the volume fraction of the down-polarized domain
electrical T1,T2,s;

/*------------------------------------- Technology Parameters -------------------------------------*/

// These parameters are determined by Thales's technology

parameter real PhiH_1 = 0.678;	//Barrier potential height in volt at LSMO/BTO interface, OFF state
parameter real PhiH_2 = 0.978;	//Barrier potential height in volt at Co/BTO interface, OFF state
parameter real mH_fac = 0.931;	//Effective electron mass coefficient, OFF state
parameter real PhiL_1 = 0.530;	//Barrier potential height in volt at LSMO/BTO interface, ON state
parameter real PhiL_2 = 1.014;	//Barrier potential height in volt at Co/BTO interface, ON state
parameter real mL_fac = 0.437;	//Effective electron mass coefficient, ON state

parameter real tau0n = 2.8e-15;	//Attempt time of domain nucleation in second
parameter real tau0p = 9e-14;	//Attempt time of domain wall propagation in second
parameter real Un = 0.67;		//Creep energy barrier in volt for domain nucleation
parameter real Up = 0.52;		//Creep energy barrier in volt for domain wall propagation

/*---------------------------------------------- End ----------------------------------------------*/

/*---------------------------------------- Size Parameters ----------------------------------------*/

parameter real r = 175e-9;						//Surface radius in meter
parameter real t_B = 2e-9 from [1.2e-9:2.4e-9];	//Barrier thickness in meter

/*---------------------------------------------- End ----------------------------------------------*/

/*------------------------------------- Simulation Parameters -------------------------------------*/

parameter real sim_step = 1e-10;		//Time step in second for simulation
parameter real s_OFF = 0.9 from (0:1);	//Initial volume fraction of the down-polarized domain
parameter real T = 300;					//Temperature

/*---------------------------------------------- End ----------------------------------------------*/

/*------------------------------------------- Variables -------------------------------------------*/

real area;			//Surface area of junction

real FH1_pos;		//Fitting factor for FN tunneling, positive bias, OFF state
real FH2_pos;		//Fitting factor for FN tunneling, positive bias, OFF state
real FH1_neg;		//Fitting factor for FN tunneling, negative bias, OFF state
real FH2_neg;		//Fitting factor for FN tunneling, negative bias, OFF state
real FL1_pos;		//Fitting factor for FN tunneling, positive bias, ON state
real FL2_pos;		//Fitting factor for FN tunneling, positive bias, ON state
real FL1_neg;		//Fitting factor for FN tunneling, negative bias, ON state
real FL2_neg;		//Fitting factor for FN tunneling, negative bias, ON state

real TransH_pos;	//Transition voltage between DT and FNT, positive bias, OFF state
real TransH_neg;	//Transition voltage between DT and FNT, negative bias, OFF state
real TransL_pos;	//Transition voltage between DT and FNT, positive bias, ON state
real TransL_neg;	//Transition voltage between DT and FNT, negative bias, ON state

real IH;			//Current for OFF state
real IL;			//Current for ON state

real FacH_C;		//Factor used in Gruverman model, OFF state
real FacH_alpha;	//Factor used in Gruverman model, OFF state
real FacL_C;		//Factor used in Gruverman model, ON state
real FacL_alpha;	//Factor used in Gruverman model, ON state

real mH;			//Effective electron mass, OFF state
real mL;			//Effective electron mass, ON state

real taun;			//Nucleation time in second
real taup;			//Characteristic propagation time in second

real Vb;			//Voltage across the FTM from T1 to T2
real Id;			//Current through the FTM from T1 to T2

real t_pre;			//Last simulation time recorded
real t_rel;			//Relative time with respect to a single KAI curve

real s_OFF_real;	//Real-time volume fraction of down-polarized domain during the simulation
real s_ON_real;		//Real-time volume fraction of up-polarized domain during the simulation

integer NucleReq;	//Flag indicating whether nucleation activation is required or not
					//0, no nucleation is required; 1, nucleation is required for ON-to-OFF switching
					//-1, nucleation is required for OFF-to-ON switching

real NucleStage_HL;	//Percentage of the proceeding nucleation activation for OFF-to-ON switching
real NucleStage_LH;	//Percentage of the proceeding nucleation activation for ON-to-OFF switching

integer Num_t_B;	//Number of the unit cell in the barrier
integer IsTrue_t_B; //Flag indicating whether the barrier thickness is reasonable or not

/*---------------------------------------------- End ----------------------------------------------*/

/*-------------------------------------------- Analog ---------------------------------------------*/
analog	begin

	//Initialization
	@(initial_step)	begin
		IsTrue_t_B = (t_B*1e10)%4;
		if(IsTrue_t_B != 0) begin
			$strobe("Warning: Specified t_B = %g not reasonable!",t_B);
			$finish(0);
		end

		area = `PI*r*r;
		t_pre = $abstime;
		s_OFF_real = s_OFF;
		s_ON_real = 1.0 - s_OFF_real;

		TransH_pos = PhiH_2;
		TransH_neg = -PhiH_1;
		TransL_pos = PhiL_2;
		TransL_neg = -PhiL_1;

		mH = mH_fac*`m;
		mL = mL_fac*`m;

		FacH_C = -4*mH*pow(`e,3)/(9*`PI*`PI*pow(`hbas,3));
		FacL_C = -4*mL*pow(`e,3)/(9*`PI*`PI*pow(`hbas,3));

		FH2_pos = 0.7608;
		FH2_neg = 0.283;
		FL2_pos = 9.41e-2;
		FL2_neg = 1.2e-3;

		Num_t_B = (t_B*1e10)/4.0;

		case(Num_t_B)
			3: begin
				FH1_pos = 3.739e-2;
				FH1_neg = 3.55e-2;
				FL1_pos = 7.211e-3;
				FL1_neg = 1.354e-2;
			end
			4: begin
				FH1_pos = 9.795e-3;
				FH1_neg = 6.517e-3;
				FL1_pos = 1.605e-3;
				FL1_neg = 2.133e-3;
			end
			5: begin
				FH1_pos = 2.6e-3;
				FH1_neg = 1.2e-3;
				FL1_pos = 3.549e-4;
				FL1_neg = 3.273e-4;
			end
			6: begin
				FH1_pos = 6.707e-4;
				FH1_neg = 2.168e-4;
				FL1_pos = 7.843e-5;
				FL1_neg = 4.964e-5;
			end
			default: begin
				$strobe("Warning: Specified t_B = %g not reasonable!",t_B);
				$finish(0);
			end
		endcase

		NucleStage_HL = 0;
		NucleStage_LH = 0;

	end
	//Initialization ends here

	Vb=V(T1,T2);

	if(abs(Vb+PhiH_1-PhiH_2) <= 1e-6)	begin
		Vb = PhiH_2-PhiH_1+1e-4;			//Reset the polar point to avoid zero denominator
	end

	if(abs(Vb+PhiL_1-PhiL_2) <= 1e-6)	begin
		Vb = PhiL_2-PhiL_1+1e-4;			//Reset the polar point to avoid zero denominator
	end

	FacH_alpha = 4*t_B*sqrt(2*mH*`e)/(3*`hbas*(PhiH_1+Vb-PhiH_2));
	FacL_alpha = 4*t_B*sqrt(2*mL*`e)/(3*`hbas*(PhiL_1+Vb-PhiL_2));

	//Calculate the current for OFF state
	if(Vb > TransH_neg && Vb < TransH_pos)	begin	//Direct tunneling occurs
			IH = area*FacH_C*limexp(FacH_alpha*(pow((PhiH_2-0.5*Vb),1.5) - pow((PhiH_1+0.5*Vb),1.5)))*
				(sinh(0.75*FacH_alpha*Vb*(pow((PhiH_2-0.5*Vb),0.5) - pow((PhiH_1+0.5*Vb),0.5))))/
				(FacH_alpha*FacH_alpha*pow((pow((PhiH_2-0.5*Vb),0.5) - pow((PhiH_1+0.5*Vb),0.5)),2));
		end
	else if(Vb >= TransH_pos)	begin				//FN tunneling occurs
			IH = FH1_pos*area*`e*`e*`m*Vb*Vb*limexp(-FH2_pos*4*t_B*sqrt(2*mH*`e)*pow(PhiH_1,1.5)/(3*`hbas*abs(Vb)))/
				(16*`PI*`PI*`hbas*mH*PhiH_1*t_B*t_B);
		end
	else if(Vb <= TransH_neg)	begin				//FN tunneling occurs
			IH = -(FH1_neg*area*`e*`e*`m*Vb*Vb*limexp(-FH2_neg*4*t_B*sqrt(2*mH*`e)*pow(PhiH_2,1.5)/(3*`hbas*abs(Vb)))/
				(16*`PI*`PI*`hbas*mH*PhiH_2*t_B*t_B));
	end

	//Calculate the current for ON state
	if(Vb > TransL_neg && Vb < TransL_pos)	begin	//Direct tunneling occurs
			IL = area*FacL_C*limexp(FacL_alpha*(pow((PhiL_2-0.5*Vb),1.5) - pow((PhiL_1+0.5*Vb),1.5)))*
				(sinh(0.75*FacL_alpha*Vb*(pow((PhiL_2-0.5*Vb),0.5) - pow((PhiL_1+0.5*Vb),0.5))))/
				(FacL_alpha*FacL_alpha*pow((pow((PhiL_2-0.5*Vb),0.5) - pow((PhiL_1+0.5*Vb),0.5)),2));
		end
	else if(Vb >= TransL_pos)	begin				//FN tunneling occurs
			IL = FL1_pos*area*`e*`e*`m*Vb*Vb*limexp(-FL2_pos*4*t_B*sqrt(2*mL*`e)*pow(PhiL_1,1.5)/(3*`hbas*abs(Vb)))/
				(16*`PI*`PI*`hbas*mL*PhiL_1*t_B*t_B);
		end
	else if(Vb <= TransL_neg)	begin				//FN tunneling occurs
			IL = -(FL1_neg*area*`e*`e*`m*Vb*Vb*limexp(-FL2_neg*4*t_B*sqrt(2*mL*`e)*pow(PhiL_2,1.5)/(3*`hbas*abs(Vb)))/
				(16*`PI*`PI*`hbas*mL*PhiL_2*t_B*t_B));
	end

	//Check if nucleation is required
	if(Vb > 0) begin
		if(s_OFF_real < 1e-4 && NucleStage_LH < 1) begin		//require nucleation process while switching toward OFF state
			NucleReq = 1;
			NucleStage_HL = 0;
		end
		else if(s_OFF_real < 1e-4 && NucleStage_LH >= 1) begin	//nucleation is finished, but sOFF is still smaller than critical value
			NucleReq = 0;
			NucleStage_LH = 0;
			NucleStage_HL = 0;
			s_OFF_real = 1e-4;
		end
		else begin												//no nucleation process is required
			NucleReq = 0;
			NucleStage_LH = 0;
			NucleStage_HL = 0;
		end
	end

	if(Vb < 0) begin
		if(s_ON_real < 1e-4 && NucleStage_HL < 1) begin			//require nucleation process while switching toward ON state
			NucleReq = -1;
			NucleStage_LH = 0;
		end
		else if(s_ON_real < 1e-4 && NucleStage_HL >= 1) begin	//nucleation is finished, but sON is still smaller than critical value
			NucleReq = 0;
			NucleStage_LH = 0;
			NucleStage_HL = 0;
			s_ON_real = 1e-4;
		end
		else begin												//no nucleation process is required
			NucleReq = 0;
			NucleStage_LH = 0;
			NucleStage_HL = 0;
		end
	end

	//Case 1: Positive bias voltage, Trigger the nucleation of down-polarized domain
	if(Vb > 0 && NucleReq == 1)	begin
		taun = tau0n*limexp(t_B*Un*`e*`E0/(`kB*T*abs(Vb)));
		NucleStage_LH = NucleStage_LH + ($abstime - t_pre)/taun;
		t_pre = $abstime;
	end

	//Case 2: Negative bias voltage, Trigger the nucleation of up-polarized domain
	if(Vb < 0 && NucleReq == -1)	begin
    	taun = tau0n*limexp(t_B*Un*`e*`E0/(`kB*T*abs(Vb)));
    	NucleStage_HL = NucleStage_HL + ($abstime - t_pre)/taun;
		t_pre = $abstime;
	end

	//Case 3: Positive bias voltage, Drive the down-polarized domain wall propagation
	if(Vb > 0 && NucleReq == 0)	begin
		taup = tau0p*limexp(t_B*Up*`e*`E0/(`kB*T*abs(Vb)));
		t_rel = taup*sqrt(ln(1/(1-s_OFF_real)));
		s_OFF_real = 1 - limexp(-pow((t_rel + $abstime - t_pre)/taup,2));
		s_ON_real = 1 - s_OFF_real;
		t_pre = $abstime;
	end

	//Case 4: Negative bias voltage, Drive the up-polarized domain wall propagation
	if(Vb < 0 && NucleReq == 0)	begin
		taup = tau0p*limexp(t_B*Up*`e*`E0/(`kB*T*abs(Vb)));
		t_rel = taup*sqrt(ln(1/(1-s_ON_real)));
		s_ON_real = 1 - limexp(-pow((t_rel + $abstime - t_pre)/taup,2));
		s_OFF_real = 1 - s_ON_real;
		t_pre = $abstime;
	end

	//Results
	Id = IH*s_OFF_real + IL*s_ON_real;
	I(T1,T2)<+(Id);
	V(s)<+(s_OFF_real);

	//Set the time step
	$bound_step(sim_step);

end

/*---------------------------------------------- End ----------------------------------------------*/

endmodule
